# Ansys Electronics Desktop project, version 2018.0
materials:
  vacuum: permittivity=1
  copper: permeability=0.999991 conductivity=58000000
  FR4_epoxy: permittivity=4.4 dielectric_loss_tangent=0.02
  pec: conductivity=1e+030

design single_dipole (HFSS, DrivenModal, model units mm)
variables:
  l = 25mm-delta/2  # dlina plecha (arm length)
  a = 0.2mm  # vibrator radius
  delta = 0.2mm  # zazor (gap)
  A_box = 50mm  # box-radiation radius
  L_box = 100mm  # dlina box-radiation( box length)
geometry:
  Cylinder1 [pec] = cylinder(axis=Z, base_centre=(0mm, 0mm, delta/2), radius=a, height=l)
  Cylinder2 [pec] = cylinder(axis=Z, base_centre=(0mm, 0mm, -delta/2), radius=a, height=-l)
  Rectangle1 = rectangle(corner=(-a, 0mm, -delta/2), z_size=delta, x_size=2*a)
  Cylinder3 [vacuum] = cylinder(axis=Z, base_centre=(0mm, 0mm, -L_box/2), radius=A_box, height=L_box)
boundaries and excitations:
  Rad1: Radiation Objects=Cylinder3
  1: Lumped Port Faces=Rectangle1.face Modes{Mode1{IntLine{middle of Rectangle1.edge(z opposite corner) -> middle of Rectangle1.edge(z at corner)} CharImp=Zpi RenormImp=65ohm}} Impedance=50ohm
setups:
  Setup1: HfssDriven AdaptMultipleFreqs MultipleAdaptiveFreqsSetup{3GHz(0.02) 4.8GHz(0.02) 9GHz(0.02)} MaximumPasses=20 MinimumPasses=1 MinimumConvergedPasses=2 PercentRefinement=30 BasisOrder=1 PortAccuracy=2
    sweep Sweep: 1GHz to 10GHz, 451 points; Type=Interpolating InterpTolerance=0.5 InterpMaxSolns=250 InterpUsePortImped=false PassivityErrorTolerance=0.0001
source amplitudes:
  1:1: 1W 0deg
radiation setups:
  Infinite Sphere1: Infinite Sphere Theta=-180deg..180deg step 2deg Phi=0deg..90deg step 90deg
  Infinite Sphere2: Infinite Sphere Theta=0deg..180deg step 2deg Phi=-180deg..180deg step 2deg
output variables:
  Z75 = 75
field plots:
  Mag_Jsurf1: Jsurf over Cylinder2.face(all 3) Cylinder1.face(all 3) on Setup1 : LastAdaptive at Freq=3GHz Phase=0deg
reports:
  S Parameter Chart 1: S(1,1) on Setup1 : Sweep [Freq=all]; markers m1 at 1GHz, m2 at 2GHz, m3 at 2.82GHz, m4 at 4GHz, m5 at 5GHz, m6 at 6GHz, m7 at 7GHz, m8 at 8GHz, m9 at 9GHz, m10 at 10GHz
  Z Parameter Plot 1: re(Z(1,1)), im(Z(1,1)) vs Freq on Setup1 : Sweep
  rE Plot 1: dB20normalize(rETheta) vs Theta on Setup1 : LastAdaptive, Infinite Sphere1 [Phi=all Freq=3GHz]
  rE Plot 2: mag(rETheta) vs Theta on Setup1 : LastAdaptive, Infinite Sphere1 [Phi=all Freq=3GHz]
  rE Plot 3: dB20normalize(rETheta) vs Theta on Setup1 : LastAdaptive, Infinite Sphere1 [Phi=all Freq=6GHz]
  rE Plot 4: mag(rETheta) vs Theta on Setup1 : LastAdaptive, Infinite Sphere1 [Phi=all Freq=6GHz]
  rE Plot 5: dB20normalize(rETheta) vs Theta on Setup1 : LastAdaptive, Infinite Sphere1 [Phi=all Freq=9GHz]
  rE Plot 6: mag(rETheta) vs Theta on Setup1 : LastAdaptive, Infinite Sphere1 [Phi=all Freq=9GHz]
  rE Plot 7: mag(rETheta) vs Phi, Theta on Setup1 : LastAdaptive, Infinite Sphere2 [Freq=3GHz]

design dipole_from_library (HFSS, DrivenModal, model units mm)
geometry:
  Dipole_Antenna_WithAirbox1 = component(Dipole_Antenna_WithAirbox, 3D_Component_File_Path=<syslib>/3DComponents/HFSS/Antennas/Dipole/Dipole_Antenna_WithAirbox_DM.a3dcomp, wire_rad=0.02cm, dipole_length=5cm, port_gap=0.02cm, Airbox_dist=4cm)
  arm1_2, arm1_1_1 [pec] = part_of(Dipole_Antenna_WithAirbox1)
  port1_1, AirBox [vacuum] = part_of(Dipole_Antenna_WithAirbox1)
boundaries and excitations:
  Dipole_Antenna_WithAirbox1_Rad: FE-BI Objects=AirBox UseAdaptiveIE
  Dipole_Antenna_WithAirbox1_p1: Lumped Port Objects=port1_1 Modes{Mode1{IntLine{middle of port1_1.edge(#58) -> middle of port1_1.edge(#60)} CharImp=Zpi RenormImp=50ohm}} Impedance=50ohm
setups:
  Setup1: HfssDriven AdaptMultipleFreqs MultipleAdaptiveFreqsSetup{3GHz(0.02) 6GHz(0.02) 9GHz(0.02)} MaximumPasses=20 MinimumPasses=1 MinimumConvergedPasses=1 PercentRefinement=30 BasisOrder=1 PortAccuracy=2 UseDomains DDMSolverResidual=0.0001
    sweep Sweep: 1GHz to 10GHz, 451 points; Type=Interpolating InterpTolerance=0.5 InterpMaxSolns=250 InterpUsePortImped=false PassivityErrorTolerance=0.0001
source amplitudes:
  Dipole_Antenna_WithAirbox1_p1:1: 1W 0deg
radiation setups:
  Infinite Sphere1: Infinite Sphere Theta=-180deg..180deg step 2deg Phi=0deg..0deg step 2deg
  Infinite Sphere2: Infinite Sphere Theta=0deg..180deg step 2deg Phi=-180deg..180deg step 2deg
reports:
  S Parameter Chart 1: S(Dipole_Antenna_WithAirbox1_p1,Dipole_Antenna_WithAirbox1_p1) on Setup1 : Sweep [Freq=all]
  Z Parameter Plot 1: re(Z(Dipole_Antenna_WithAirbox1_p1,Dipole_Antenna_WithAirbox1_p1)), im(Z(Dipole_Antenna_WithAirbox1_p1,Dipole_Antenna_WithAirbox1_p1)) vs Freq on Setup1 : Sweep
  rE Plot 1: mag(rEPhi), mag(rETheta) vs Theta on Setup1 : LastAdaptive, Infinite Sphere1 [Phi=all Freq=3GHz]
  Gain Plot 1: GainTotal vs Phi, Theta on Setup1 : LastAdaptive, Infinite Sphere2 [Freq=3GHz]
  Gain Plot 2: GainTotal vs Theta on Setup1 : LastAdaptive, Infinite Sphere1 [Phi=all Freq=3GHz]

design dipole_over_plate (HFSS, DrivenModal, model units mm)
variables:
  a = 1mm  # dipole_radius
  gap = 1mm  # zazor_mezhdu_plechami
  l = 50mm  # dipole_length
  h = 25mm  # elevation above the plane
  A_box = 100mm
  B_box = 50mm
  C_box = 50mm
geometry:
  Cylinder1 [vacuum] = cylinder(axis=Y, base_centre=(0mm, -l/2, 0mm), radius=1mm, height=(l-gap)/2)
  Cylinder2 [vacuum] = cylinder(axis=Y, base_centre=(0mm, gap/2, 0mm), radius=1mm, height=(l-gap)/2)
  Rectangle1 = rectangle(corner=(-a, -gap/2, 0mm), x_size=2*a, y_size=gap)
  Rectangle2 = rectangle(corner=(-C_box/2, -A_box/2, -h), x_size=C_box, y_size=A_box)
  Box1 [vacuum] = box(corner=(-C_box/2, -(A_box+l)/2, -B_box/2-h), size=(C_box, A_box+l, B_box+h))
boundaries and excitations:
  PerfE1: Perfect E Objects=Rectangle2
  Rad1: Radiation Objects=Box1
  1: Lumped Port Faces=Rectangle1.face Modes{Mode1{IntLine{middle of Rectangle1.edge(y at corner) -> middle of Rectangle1.edge(y opposite corner)} CharImp=Zpi RenormImp=50ohm}} Impedance=50ohm
setups:
  Setup1: HfssDriven Frequency=3GHz MaxDeltaS=0.02 MaximumPasses=20 MinimumPasses=1 MinimumConvergedPasses=1 PercentRefinement=30 BasisOrder=1 PortAccuracy=2
    sweep Sweep: 2.5GHz to 3.5GHz, 451 points; Type=Interpolating InterpTolerance=0.5 InterpMaxSolns=250 InterpUsePortImped=false PassivityErrorTolerance=0.0001
source amplitudes:
  1:1: 1W 0deg
